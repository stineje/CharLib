.subckt DFFSR vss vdd DATA NSET NRST Q CLK
M0 a_2_6# NRST vdd vdd pfet w=4u l=0.4u
+ ad=0p pd=0u as=0p ps=0u
M1 vdd a_10_61# a_2_6# vdd pfet w=4u l=0.4u
+ ad=0p pd=0u as=0p ps=0u
M2 a_10_61# a_23_27# vdd vdd pfet w=4u l=0.4u
+ ad=0p pd=0u as=0p ps=0u
M3 vdd NSET a_10_61# vdd pfet w=4u l=0.4u
+ ad=0p pd=0u as=0p ps=0u
M4 a_23_27# a_47_71# a_2_6# vdd pfet w=2u l=0.4u
+ ad=0p pd=0u as=0p ps=0u
M5 a_57_6# a_47_4# a_23_27# vdd pfet w=2u l=0.4u
+ ad=0p pd=0u as=0p ps=0u
M6 vdd DATA a_57_6# vdd pfet w=4u l=0.4u
+ ad=0p pd=0u as=0p ps=0u
M7 vdd a_47_71# a_47_4# vdd pfet w=4u l=0.4u
+ ad=0p pd=0u as=0p ps=0u
M8 a_47_71# CLK vdd vdd pfet w=4u l=0.4u
+ ad=0p pd=0u as=0p ps=0u
M9 a_105_6# a_47_71# a_10_61# vdd pfet w=2u l=0.4u
+ ad=0p pd=0u as=0p ps=0u
M10 a_113_6# a_47_4# a_105_6# vdd pfet w=2u l=0.4u
+ ad=0p pd=0u as=0p ps=0u
M11 a_122_6# a_105_6# vdd vdd pfet w=4u l=0.4u
+ ad=0p pd=0u as=0p ps=0u
M12 vdd NRST a_122_6# vdd pfet w=4u l=0.4u
+ ad=0p pd=0u as=0p ps=0u
M13 a_113_6# a_122_6# vdd vdd pfet w=4u l=0.4u
+ ad=0p pd=0u as=0p ps=0u
M14 vdd NSET a_113_6# vdd pfet w=4u l=0.4u
+ ad=0p pd=0u as=0p ps=0u
M15 vdd a_122_6# Q vdd pfet w=4u l=0.4u
+ ad=0p pd=0u as=0p ps=0u
M16 a_10_6# NRST a_2_6# Gnd nfet w=4u l=0.4u
+ ad=0p pd=0u as=0p ps=0u
M17 vss a_10_61# a_10_6# Gnd nfet w=4u l=0.4u
+ ad=0p pd=0u as=0p ps=0u
M18 a_26_6# a_23_27# vss Gnd nfet w=4u l=0.4u
+ ad=0p pd=0u as=0p ps=0u
M19 a_10_61# NSET a_26_6# Gnd nfet w=4u l=0.4u
+ ad=0p pd=0u as=0p ps=0u
M20 a_23_27# a_47_4# a_2_6# Gnd nfet w=2u l=0.4u
+ ad=0p pd=0u as=0p ps=0u
M21 a_57_6# a_47_71# a_23_27# Gnd nfet w=2u l=0.4u
+ ad=0p pd=0u as=0p ps=0u
M22 vss DATA a_57_6# Gnd nfet w=2u l=0.4u
+ ad=0p pd=0u as=0p ps=0u
M23 vss a_47_71# a_47_4# Gnd nfet w=2u l=0.4u
+ ad=0p pd=0u as=0p ps=0u
M24 a_47_71# CLK vss Gnd nfet w=2u l=0.4u
+ ad=0p pd=0u as=0p ps=0u
M25 a_105_6# a_47_4# a_10_61# Gnd nfet w=2u l=0.4u
+ ad=0p pd=0u as=0p ps=0u
M26 a_113_6# a_47_71# a_105_6# Gnd nfet w=2u l=0.4u
+ ad=0p pd=0u as=0p ps=0u
M27 a_130_6# a_105_6# a_122_6# Gnd nfet w=4u l=0.4u
+ ad=0p pd=0u as=0p ps=0u
M28 vss NRST a_130_6# Gnd nfet w=4u l=0.4u
+ ad=0p pd=0u as=0p ps=0u
M29 a_146_6# a_122_6# vss Gnd nfet w=4u l=0.4u
+ ad=0p pd=0u as=0p ps=0u
M30 a_113_6# NSET a_146_6# Gnd nfet w=4u l=0.4u
+ ad=0p pd=0u as=0p ps=0u
M31 vss a_122_6# Q Gnd nfet w=2u l=0.4u
+ ad=0p pd=0u as=0p ps=0u
.ends DFFSR
