.subckt NAND2X1 vdd Y vss A B
M0 Y A vdd vdd pfet w=4u l=0.4u
+ ad=0p pd=0u as=0p ps=0u
M1 vdd B Y vdd pfet w=4u l=0.4u
+ ad=0p pd=0u as=0p ps=0u
M2 a_9_6# A vss Gnd nfet w=4u l=0.4u
+ ad=0p pd=0u as=0p ps=0u
M3 Y B a_9_6# Gnd nfet w=4u l=0.4u
+ ad=0p pd=0u as=0p ps=0u
.ends NAND2X1
