.subckt DFFPOSX1 vdd DATA gnd Q CLK
M0 vdd CLK a_2_6# vdd pfet w=8u l=0.4u
+ ad=0p pd=0u as=0p ps=0u
M1 a_17_74# DATA vdd vdd pfet w=4u l=0.4u
+ ad=0p pd=0u as=0p ps=0u
M2 a_22_6# CLK a_17_74# vdd pfet w=4u l=0.4u
+ ad=0p pd=0u as=0p ps=0u
M3 a_31_74# a_2_6# a_22_6# vdd pfet w=4u l=0.4u
+ ad=0p pd=0u as=0p ps=0u
M4 vdd a_34_4# a_31_74# vdd pfet w=4u l=0.4u
+ ad=0p pd=0u as=0p ps=0u
M5 a_34_4# a_22_6# vdd vdd pfet w=4u l=0.4u
+ ad=0p pd=0u as=0p ps=0u
M6 a_61_74# a_34_4# vdd vdd pfet w=4u l=0.4u
+ ad=0p pd=0u as=0p ps=0u
M7 a_66_6# a_2_6# a_61_74# vdd pfet w=4u l=0.4u
+ ad=0p pd=0u as=0p ps=0u
M8 a_76_84# CLK a_66_6# vdd pfet w=2u l=0.4u
+ ad=0p pd=0u as=0p ps=0u
M9 vdd Q a_76_84# vdd pfet w=2u l=0.4u
+ ad=0p pd=0u as=0p ps=0u
M10 gnd CLK a_2_6# Gnd nfet w=4u l=0.4u
+ ad=0p pd=0u as=0p ps=0u
M11 Q a_66_6# vdd vdd pfet w=8u l=0.4u
+ ad=0p pd=0u as=0p ps=0u
M12 a_17_6# DATA gnd Gnd nfet w=2u l=0.4u
+ ad=0p pd=0u as=0p ps=0u
M13 a_22_6# a_2_6# a_17_6# Gnd nfet w=2u l=0.4u
+ ad=0p pd=0u as=0p ps=0u
M14 a_31_6# CLK a_22_6# Gnd nfet w=2u l=0.4u
+ ad=0p pd=0u as=0p ps=0u
M15 gnd a_34_4# a_31_6# Gnd nfet w=2u l=0.4u
+ ad=0p pd=0u as=0p ps=0u
M16 a_34_4# a_22_6# gnd Gnd nfet w=2u l=0.4u
+ ad=0p pd=0u as=0p ps=0u
M17 a_61_6# a_34_4# gnd Gnd nfet w=2u l=0.4u
+ ad=0p pd=0u as=0p ps=0u
M18 a_66_6# CLK a_61_6# Gnd nfet w=2u l=0.4u
+ ad=0p pd=0u as=0p ps=0u
M19 a_76_6# a_2_6# a_66_6# Gnd nfet w=2u l=0.4u
+ ad=0p pd=0u as=0p ps=0u
M20 gnd Q a_76_6# Gnd nfet w=2u l=0.4u
+ ad=0p pd=0u as=0p ps=0u
M21 Q a_66_6# gnd Gnd nfet w=4u l=0.4u
+ ad=0p pd=0u as=0p ps=0u
.ends DFFPOSX1
